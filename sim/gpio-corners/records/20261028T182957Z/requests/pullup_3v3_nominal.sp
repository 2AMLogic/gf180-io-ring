* GPIO cell (design/gpio.spice), deck pullup, 3v3 mode: pull-up equivalent R, PAD held at DVDD/2, OE=IE=0, PU=1
* Generated by gen_requests.py. Nine independent instances, one per (DVDD, VDD) pair.
.include /home/ubuntu/.volare/volare/gf180mcu/versions/c6d73a35f524070e85faff4a6a9eef49553ebc2b/gf180mcuD/libs.tech/ngspice/design.ngspice
.include gpio.spice
Vdvdd_d1v1 dvdd_d1v1 0 3.3
Vvdd_d1v1 vdd_d1v1 0 3.3
Va_d1v1 a_d1v1 0 0
Voe_d1v1 oe_d1v1 0 0
Vie_d1v1 ie_d1v1 0 0
Vpu_d1v1 pu_d1v1 0 3.3
Vpd_d1v1 pd_d1v1 0 0
Vpad_d1v1 pad_d1v1 0 DC 1.65
Xdut_d1v1 a_d1v1 oe_d1v1 ie_d1v1 pu_d1v1 pd_d1v1 y_d1v1 pad_d1v1 dvdd_d1v1 vdd_d1v1 0 0 gpio
