* GPIO cell (design/gpio.spice), deck esd_rail, - mode: DVDD-DVSS rail clamp, ESD-like current pulse
* Generated by gen_requests.py. Nine independent instances, one per (DVDD, VDD) pair.
.include /home/ubuntu/.volare/volare/gf180mcu/versions/c6d73a35f524070e85faff4a6a9eef49553ebc2b/gf180mcuD/libs.tech/ngspice/design.ngspice
.include dvdd_pad.spice
.options itl4=1000 gmin=1e-9 reltol=0.01 abstol=1e-10 rshunt=1e12
Rleak dvdd 0 1Meg
Ipulse 0 dvdd PULSE(0 1.33 1n 10n 10n 100n 1)
Xrail dvdd 0 0 0 dvdd_pad
