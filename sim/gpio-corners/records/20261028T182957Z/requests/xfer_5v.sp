* GPIO cell (design/gpio.spice), deck xfer, 5v mode: input transfer curve: slow PAD ramp up then down, OE=0, IE=1
* Generated by gen_requests.py. Nine independent instances, one per (DVDD, VDD) pair.
.include /home/ubuntu/.volare/volare/gf180mcu/versions/c6d73a35f524070e85faff4a6a9eef49553ebc2b/gf180mcuD/libs.tech/ngspice/design.ngspice
.include gpio.spice
Vdvdd_d0v0 dvdd_d0v0 0 4.5
Vvdd_d0v0 vdd_d0v0 0 2.97
Va_d0v0 a_d0v0 0 0
Voe_d0v0 oe_d0v0 0 0
Vie_d0v0 ie_d0v0 0 2.97
Vpu_d0v0 pu_d0v0 0 0
Vpd_d0v0 pd_d0v0 0 0
Vpad_d0v0 pad_d0v0 0 PWL(0 0 100u 4.5 200u 0)
Xdut_d0v0 a_d0v0 oe_d0v0 ie_d0v0 pu_d0v0 pd_d0v0 y_d0v0 pad_d0v0 dvdd_d0v0 vdd_d0v0 0 0 gpio
Vdvdd_d0v1 dvdd_d0v1 0 4.5
Vvdd_d0v1 vdd_d0v1 0 3.3
Va_d0v1 a_d0v1 0 0
Voe_d0v1 oe_d0v1 0 0
Vie_d0v1 ie_d0v1 0 3.3
Vpu_d0v1 pu_d0v1 0 0
Vpd_d0v1 pd_d0v1 0 0
Vpad_d0v1 pad_d0v1 0 PWL(0 0 100u 4.5 200u 0)
Xdut_d0v1 a_d0v1 oe_d0v1 ie_d0v1 pu_d0v1 pd_d0v1 y_d0v1 pad_d0v1 dvdd_d0v1 vdd_d0v1 0 0 gpio
Vdvdd_d0v2 dvdd_d0v2 0 4.5
Vvdd_d0v2 vdd_d0v2 0 3.63
Va_d0v2 a_d0v2 0 0
Voe_d0v2 oe_d0v2 0 0
Vie_d0v2 ie_d0v2 0 3.63
Vpu_d0v2 pu_d0v2 0 0
Vpd_d0v2 pd_d0v2 0 0
Vpad_d0v2 pad_d0v2 0 PWL(0 0 100u 4.5 200u 0)
Xdut_d0v2 a_d0v2 oe_d0v2 ie_d0v2 pu_d0v2 pd_d0v2 y_d0v2 pad_d0v2 dvdd_d0v2 vdd_d0v2 0 0 gpio
Vdvdd_d1v0 dvdd_d1v0 0 5.0
Vvdd_d1v0 vdd_d1v0 0 2.97
Va_d1v0 a_d1v0 0 0
Voe_d1v0 oe_d1v0 0 0
Vie_d1v0 ie_d1v0 0 2.97
Vpu_d1v0 pu_d1v0 0 0
Vpd_d1v0 pd_d1v0 0 0
Vpad_d1v0 pad_d1v0 0 PWL(0 0 100u 5.0 200u 0)
Xdut_d1v0 a_d1v0 oe_d1v0 ie_d1v0 pu_d1v0 pd_d1v0 y_d1v0 pad_d1v0 dvdd_d1v0 vdd_d1v0 0 0 gpio
Vdvdd_d1v1 dvdd_d1v1 0 5.0
Vvdd_d1v1 vdd_d1v1 0 3.3
Va_d1v1 a_d1v1 0 0
Voe_d1v1 oe_d1v1 0 0
Vie_d1v1 ie_d1v1 0 3.3
Vpu_d1v1 pu_d1v1 0 0
Vpd_d1v1 pd_d1v1 0 0
Vpad_d1v1 pad_d1v1 0 PWL(0 0 100u 5.0 200u 0)
Xdut_d1v1 a_d1v1 oe_d1v1 ie_d1v1 pu_d1v1 pd_d1v1 y_d1v1 pad_d1v1 dvdd_d1v1 vdd_d1v1 0 0 gpio
Vdvdd_d1v2 dvdd_d1v2 0 5.0
Vvdd_d1v2 vdd_d1v2 0 3.63
Va_d1v2 a_d1v2 0 0
Voe_d1v2 oe_d1v2 0 0
Vie_d1v2 ie_d1v2 0 3.63
Vpu_d1v2 pu_d1v2 0 0
Vpd_d1v2 pd_d1v2 0 0
Vpad_d1v2 pad_d1v2 0 PWL(0 0 100u 5.0 200u 0)
Xdut_d1v2 a_d1v2 oe_d1v2 ie_d1v2 pu_d1v2 pd_d1v2 y_d1v2 pad_d1v2 dvdd_d1v2 vdd_d1v2 0 0 gpio
Vdvdd_d2v0 dvdd_d2v0 0 5.5
Vvdd_d2v0 vdd_d2v0 0 2.97
Va_d2v0 a_d2v0 0 0
Voe_d2v0 oe_d2v0 0 0
Vie_d2v0 ie_d2v0 0 2.97
Vpu_d2v0 pu_d2v0 0 0
Vpd_d2v0 pd_d2v0 0 0
Vpad_d2v0 pad_d2v0 0 PWL(0 0 100u 5.5 200u 0)
Xdut_d2v0 a_d2v0 oe_d2v0 ie_d2v0 pu_d2v0 pd_d2v0 y_d2v0 pad_d2v0 dvdd_d2v0 vdd_d2v0 0 0 gpio
Vdvdd_d2v1 dvdd_d2v1 0 5.5
Vvdd_d2v1 vdd_d2v1 0 3.3
Va_d2v1 a_d2v1 0 0
Voe_d2v1 oe_d2v1 0 0
Vie_d2v1 ie_d2v1 0 3.3
Vpu_d2v1 pu_d2v1 0 0
Vpd_d2v1 pd_d2v1 0 0
Vpad_d2v1 pad_d2v1 0 PWL(0 0 100u 5.5 200u 0)
Xdut_d2v1 a_d2v1 oe_d2v1 ie_d2v1 pu_d2v1 pd_d2v1 y_d2v1 pad_d2v1 dvdd_d2v1 vdd_d2v1 0 0 gpio
Vdvdd_d2v2 dvdd_d2v2 0 5.5
Vvdd_d2v2 vdd_d2v2 0 3.63
Va_d2v2 a_d2v2 0 0
Voe_d2v2 oe_d2v2 0 0
Vie_d2v2 ie_d2v2 0 3.63
Vpu_d2v2 pu_d2v2 0 0
Vpd_d2v2 pd_d2v2 0 0
Vpad_d2v2 pad_d2v2 0 PWL(0 0 100u 5.5 200u 0)
Xdut_d2v2 a_d2v2 oe_d2v2 ie_d2v2 pu_d2v2 pd_d2v2 y_d2v2 pad_d2v2 dvdd_d2v2 vdd_d2v2 0 0 gpio
