* GPIO cell (design/gpio.spice), deck esd_pad, - mode: pad clamp diodes in the cell, forced current
* Generated by gen_requests.py. Nine independent instances, one per (DVDD, VDD) pair.
.include /home/ubuntu/.volare/volare/gf180mcu/versions/c6d73a35f524070e85faff4a6a9eef49553ebc2b/gf180mcuD/libs.tech/ngspice/design.ngspice
.include gpio.spice
Vdvdd_up_hbm dvdd_up_hbm 0 0
Vvdd_up_hbm vdd_up_hbm 0 0
Va_up_hbm a_up_hbm 0 0
Voe_up_hbm oe_up_hbm 0 0
Vie_up_hbm ie_up_hbm 0 0
Vpu_up_hbm pu_up_hbm 0 0
Vpd_up_hbm pd_up_hbm 0 0
Iforce_up_hbm 0 pad_up_hbm DC 1.33
Xdut_up_hbm a_up_hbm oe_up_hbm ie_up_hbm pu_up_hbm pd_up_hbm y_up_hbm pad_up_hbm dvdd_up_hbm vdd_up_hbm 0 0 gpio
Vdvdd_dn_hbm dvdd_dn_hbm 0 0
Vvdd_dn_hbm vdd_dn_hbm 0 0
Va_dn_hbm a_dn_hbm 0 0
Voe_dn_hbm oe_dn_hbm 0 0
Vie_dn_hbm ie_dn_hbm 0 0
Vpu_dn_hbm pu_dn_hbm 0 0
Vpd_dn_hbm pd_dn_hbm 0 0
Iforce_dn_hbm pad_dn_hbm 0 DC 1.33
Xdut_dn_hbm a_dn_hbm oe_dn_hbm ie_dn_hbm pu_dn_hbm pd_dn_hbm y_dn_hbm pad_dn_hbm dvdd_dn_hbm vdd_dn_hbm 0 0 gpio
Vdvdd_up_1ma dvdd_up_1ma 0 0
Vvdd_up_1ma vdd_up_1ma 0 0
Va_up_1ma a_up_1ma 0 0
Voe_up_1ma oe_up_1ma 0 0
Vie_up_1ma ie_up_1ma 0 0
Vpu_up_1ma pu_up_1ma 0 0
Vpd_up_1ma pd_up_1ma 0 0
Iforce_up_1ma 0 pad_up_1ma DC 0.001
Xdut_up_1ma a_up_1ma oe_up_1ma ie_up_1ma pu_up_1ma pd_up_1ma y_up_1ma pad_up_1ma dvdd_up_1ma vdd_up_1ma 0 0 gpio
Vdvdd_dn_1ma dvdd_dn_1ma 0 0
Vvdd_dn_1ma vdd_dn_1ma 0 0
Va_dn_1ma a_dn_1ma 0 0
Voe_dn_1ma oe_dn_1ma 0 0
Vie_dn_1ma ie_dn_1ma 0 0
Vpu_dn_1ma pu_dn_1ma 0 0
Vpd_dn_1ma pd_dn_1ma 0 0
Iforce_dn_1ma pad_dn_1ma 0 DC 0.001
Xdut_dn_1ma a_dn_1ma oe_dn_1ma ie_dn_1ma pu_dn_1ma pd_dn_1ma y_dn_1ma pad_dn_1ma dvdd_dn_1ma vdd_dn_1ma 0 0 gpio
