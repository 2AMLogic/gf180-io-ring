* ESD pad-clamp diode bench (circuit body; klt sim owns .control/.end).
* Generated by sim/esd_clamp/esd_clamp.py. Diodes are two-terminal: forward bias
* is anode-high whichever way the pad connects, so every forward diode is
* instantiated anode=node, cathode=0 and driven by a current source.
* Reverse bank: cathode at rn through a 0 V ammeter (dc leakage) and a 1 ohm
* sense resistor (ac: the source is ideal, so Im V(r) = -Im(I)*1 ohm and C = -Im V(r) / (2*pi*f)).
Vs s 0 0
Vr rn 0 0 ac 1
Bf_nd_a00 0 f_nd_a00 I=v(s)
Df_nd_a00 f_nd_a00 0 diode_nd2ps_06v0 area=1e-11 pj=1.26491e-05
Vm_nd_a00 rn m_nd_a00 0
Rm_nd_a00 m_nd_a00 r_nd_a00 1
Dr_nd_a00 0 r_nd_a00 diode_nd2ps_06v0 area=1e-11 pj=1.26491e-05
Bf_nd_a01 0 f_nd_a01 I=v(s)
Df_nd_a01 f_nd_a01 0 diode_nd2ps_06v0 area=1.33352e-11 pj=1.4607e-05
Vm_nd_a01 rn m_nd_a01 0
Rm_nd_a01 m_nd_a01 r_nd_a01 1
Dr_nd_a01 0 r_nd_a01 diode_nd2ps_06v0 area=1.33352e-11 pj=1.4607e-05
Bf_nd_a02 0 f_nd_a02 I=v(s)
Df_nd_a02 f_nd_a02 0 diode_nd2ps_06v0 area=1.77828e-11 pj=1.68679e-05
Vm_nd_a02 rn m_nd_a02 0
Rm_nd_a02 m_nd_a02 r_nd_a02 1
Dr_nd_a02 0 r_nd_a02 diode_nd2ps_06v0 area=1.77828e-11 pj=1.68679e-05
Bf_nd_a03 0 f_nd_a03 I=v(s)
Df_nd_a03 f_nd_a03 0 diode_nd2ps_06v0 area=2.37137e-11 pj=1.94787e-05
Vm_nd_a03 rn m_nd_a03 0
Rm_nd_a03 m_nd_a03 r_nd_a03 1
Dr_nd_a03 0 r_nd_a03 diode_nd2ps_06v0 area=2.37137e-11 pj=1.94787e-05
Bf_nd_a04 0 f_nd_a04 I=v(s)
Df_nd_a04 f_nd_a04 0 diode_nd2ps_06v0 area=3.16228e-11 pj=2.24937e-05
Vm_nd_a04 rn m_nd_a04 0
Rm_nd_a04 m_nd_a04 r_nd_a04 1
Dr_nd_a04 0 r_nd_a04 diode_nd2ps_06v0 area=3.16228e-11 pj=2.24937e-05
Bf_nd_a05 0 f_nd_a05 I=v(s)
Df_nd_a05 f_nd_a05 0 diode_nd2ps_06v0 area=4.21697e-11 pj=2.59753e-05
Vm_nd_a05 rn m_nd_a05 0
Rm_nd_a05 m_nd_a05 r_nd_a05 1
Dr_nd_a05 0 r_nd_a05 diode_nd2ps_06v0 area=4.21697e-11 pj=2.59753e-05
Bf_nd_a06 0 f_nd_a06 I=v(s)
Df_nd_a06 f_nd_a06 0 diode_nd2ps_06v0 area=5.62341e-11 pj=2.99958e-05
Vm_nd_a06 rn m_nd_a06 0
Rm_nd_a06 m_nd_a06 r_nd_a06 1
Dr_nd_a06 0 r_nd_a06 diode_nd2ps_06v0 area=5.62341e-11 pj=2.99958e-05
Bf_nd_a07 0 f_nd_a07 I=v(s)
Df_nd_a07 f_nd_a07 0 diode_nd2ps_06v0 area=7.49894e-11 pj=3.46386e-05
Vm_nd_a07 rn m_nd_a07 0
Rm_nd_a07 m_nd_a07 r_nd_a07 1
Dr_nd_a07 0 r_nd_a07 diode_nd2ps_06v0 area=7.49894e-11 pj=3.46386e-05
Bf_nd_a08 0 f_nd_a08 I=v(s)
Df_nd_a08 f_nd_a08 0 diode_nd2ps_06v0 area=1e-10 pj=4e-05
Vm_nd_a08 rn m_nd_a08 0
Rm_nd_a08 m_nd_a08 r_nd_a08 1
Dr_nd_a08 0 r_nd_a08 diode_nd2ps_06v0 area=1e-10 pj=4e-05
Bf_nd_a09 0 f_nd_a09 I=v(s)
Df_nd_a09 f_nd_a09 0 diode_nd2ps_06v0 area=1.33352e-10 pj=4.61913e-05
Vm_nd_a09 rn m_nd_a09 0
Rm_nd_a09 m_nd_a09 r_nd_a09 1
Dr_nd_a09 0 r_nd_a09 diode_nd2ps_06v0 area=1.33352e-10 pj=4.61913e-05
Bf_nd_a10 0 f_nd_a10 I=v(s)
Df_nd_a10 f_nd_a10 0 diode_nd2ps_06v0 area=1.77828e-10 pj=5.33409e-05
Vm_nd_a10 rn m_nd_a10 0
Rm_nd_a10 m_nd_a10 r_nd_a10 1
Dr_nd_a10 0 r_nd_a10 diode_nd2ps_06v0 area=1.77828e-10 pj=5.33409e-05
Bf_nd_a11 0 f_nd_a11 I=v(s)
Df_nd_a11 f_nd_a11 0 diode_nd2ps_06v0 area=2.37137e-10 pj=6.15971e-05
Vm_nd_a11 rn m_nd_a11 0
Rm_nd_a11 m_nd_a11 r_nd_a11 1
Dr_nd_a11 0 r_nd_a11 diode_nd2ps_06v0 area=2.37137e-10 pj=6.15971e-05
Bf_nd_a12 0 f_nd_a12 I=v(s)
Df_nd_a12 f_nd_a12 0 diode_nd2ps_06v0 area=3.16228e-10 pj=7.11312e-05
Vm_nd_a12 rn m_nd_a12 0
Rm_nd_a12 m_nd_a12 r_nd_a12 1
Dr_nd_a12 0 r_nd_a12 diode_nd2ps_06v0 area=3.16228e-10 pj=7.11312e-05
Bf_nd_a13 0 f_nd_a13 I=v(s)
Df_nd_a13 f_nd_a13 0 diode_nd2ps_06v0 area=4.21697e-10 pj=8.2141e-05
Vm_nd_a13 rn m_nd_a13 0
Rm_nd_a13 m_nd_a13 r_nd_a13 1
Dr_nd_a13 0 r_nd_a13 diode_nd2ps_06v0 area=4.21697e-10 pj=8.2141e-05
Bf_nd_a14 0 f_nd_a14 I=v(s)
Df_nd_a14 f_nd_a14 0 diode_nd2ps_06v0 area=5.62341e-10 pj=9.48549e-05
Vm_nd_a14 rn m_nd_a14 0
Rm_nd_a14 m_nd_a14 r_nd_a14 1
Dr_nd_a14 0 r_nd_a14 diode_nd2ps_06v0 area=5.62341e-10 pj=9.48549e-05
Bf_nd_a15 0 f_nd_a15 I=v(s)
Df_nd_a15 f_nd_a15 0 diode_nd2ps_06v0 area=7.49894e-10 pj=0.000109537
Vm_nd_a15 rn m_nd_a15 0
Rm_nd_a15 m_nd_a15 r_nd_a15 1
Dr_nd_a15 0 r_nd_a15 diode_nd2ps_06v0 area=7.49894e-10 pj=0.000109537
Bf_nd_a16 0 f_nd_a16 I=v(s)
Df_nd_a16 f_nd_a16 0 diode_nd2ps_06v0 area=1e-09 pj=0.000126491
Vm_nd_a16 rn m_nd_a16 0
Rm_nd_a16 m_nd_a16 r_nd_a16 1
Dr_nd_a16 0 r_nd_a16 diode_nd2ps_06v0 area=1e-09 pj=0.000126491
Bf_nd_a17 0 f_nd_a17 I=v(s)
Df_nd_a17 f_nd_a17 0 diode_nd2ps_06v0 area=1.33352e-09 pj=0.00014607
Vm_nd_a17 rn m_nd_a17 0
Rm_nd_a17 m_nd_a17 r_nd_a17 1
Dr_nd_a17 0 r_nd_a17 diode_nd2ps_06v0 area=1.33352e-09 pj=0.00014607
Bf_nd_a18 0 f_nd_a18 I=v(s)
Df_nd_a18 f_nd_a18 0 diode_nd2ps_06v0 area=1.77828e-09 pj=0.000168679
Vm_nd_a18 rn m_nd_a18 0
Rm_nd_a18 m_nd_a18 r_nd_a18 1
Dr_nd_a18 0 r_nd_a18 diode_nd2ps_06v0 area=1.77828e-09 pj=0.000168679
Bf_nd_a19 0 f_nd_a19 I=v(s)
Df_nd_a19 f_nd_a19 0 diode_nd2ps_06v0 area=2.37137e-09 pj=0.000194787
Vm_nd_a19 rn m_nd_a19 0
Rm_nd_a19 m_nd_a19 r_nd_a19 1
Dr_nd_a19 0 r_nd_a19 diode_nd2ps_06v0 area=2.37137e-09 pj=0.000194787
Bf_nd_a20 0 f_nd_a20 I=v(s)
Df_nd_a20 f_nd_a20 0 diode_nd2ps_06v0 area=3.16228e-09 pj=0.000224937
Vm_nd_a20 rn m_nd_a20 0
Rm_nd_a20 m_nd_a20 r_nd_a20 1
Dr_nd_a20 0 r_nd_a20 diode_nd2ps_06v0 area=3.16228e-09 pj=0.000224937
Bf_nd_a21 0 f_nd_a21 I=v(s)
Df_nd_a21 f_nd_a21 0 diode_nd2ps_06v0 area=4.21697e-09 pj=0.000259753
Vm_nd_a21 rn m_nd_a21 0
Rm_nd_a21 m_nd_a21 r_nd_a21 1
Dr_nd_a21 0 r_nd_a21 diode_nd2ps_06v0 area=4.21697e-09 pj=0.000259753
Bf_nd_a22 0 f_nd_a22 I=v(s)
Df_nd_a22 f_nd_a22 0 diode_nd2ps_06v0 area=5.62341e-09 pj=0.000299958
Vm_nd_a22 rn m_nd_a22 0
Rm_nd_a22 m_nd_a22 r_nd_a22 1
Dr_nd_a22 0 r_nd_a22 diode_nd2ps_06v0 area=5.62341e-09 pj=0.000299958
Bf_nd_a23 0 f_nd_a23 I=v(s)
Df_nd_a23 f_nd_a23 0 diode_nd2ps_06v0 area=7.49894e-09 pj=0.000346386
Vm_nd_a23 rn m_nd_a23 0
Rm_nd_a23 m_nd_a23 r_nd_a23 1
Dr_nd_a23 0 r_nd_a23 diode_nd2ps_06v0 area=7.49894e-09 pj=0.000346386
Bf_nd_a24 0 f_nd_a24 I=v(s)
Df_nd_a24 f_nd_a24 0 diode_nd2ps_06v0 area=1e-08 pj=0.0004
Vm_nd_a24 rn m_nd_a24 0
Rm_nd_a24 m_nd_a24 r_nd_a24 1
Dr_nd_a24 0 r_nd_a24 diode_nd2ps_06v0 area=1e-08 pj=0.0004
Bf_nd_a25 0 f_nd_a25 I=v(s)
Df_nd_a25 f_nd_a25 0 diode_nd2ps_06v0 area=1.33352e-08 pj=0.000461913
Vm_nd_a25 rn m_nd_a25 0
Rm_nd_a25 m_nd_a25 r_nd_a25 1
Dr_nd_a25 0 r_nd_a25 diode_nd2ps_06v0 area=1.33352e-08 pj=0.000461913
Bf_nd_a26 0 f_nd_a26 I=v(s)
Df_nd_a26 f_nd_a26 0 diode_nd2ps_06v0 area=1.77828e-08 pj=0.000533409
Vm_nd_a26 rn m_nd_a26 0
Rm_nd_a26 m_nd_a26 r_nd_a26 1
Dr_nd_a26 0 r_nd_a26 diode_nd2ps_06v0 area=1.77828e-08 pj=0.000533409
Bf_nd_a27 0 f_nd_a27 I=v(s)
Df_nd_a27 f_nd_a27 0 diode_nd2ps_06v0 area=2.37137e-08 pj=0.000615971
Vm_nd_a27 rn m_nd_a27 0
Rm_nd_a27 m_nd_a27 r_nd_a27 1
Dr_nd_a27 0 r_nd_a27 diode_nd2ps_06v0 area=2.37137e-08 pj=0.000615971
Bf_nd_a28 0 f_nd_a28 I=v(s)
Df_nd_a28 f_nd_a28 0 diode_nd2ps_06v0 area=3.16228e-08 pj=0.000711312
Vm_nd_a28 rn m_nd_a28 0
Rm_nd_a28 m_nd_a28 r_nd_a28 1
Dr_nd_a28 0 r_nd_a28 diode_nd2ps_06v0 area=3.16228e-08 pj=0.000711312
Bf_nd_a29 0 f_nd_a29 I=v(s)
Df_nd_a29 f_nd_a29 0 diode_nd2ps_06v0 area=4.21697e-08 pj=0.00082141
Vm_nd_a29 rn m_nd_a29 0
Rm_nd_a29 m_nd_a29 r_nd_a29 1
Dr_nd_a29 0 r_nd_a29 diode_nd2ps_06v0 area=4.21697e-08 pj=0.00082141
Bf_nd_a30 0 f_nd_a30 I=v(s)
Df_nd_a30 f_nd_a30 0 diode_nd2ps_06v0 area=5.62341e-08 pj=0.000948549
Vm_nd_a30 rn m_nd_a30 0
Rm_nd_a30 m_nd_a30 r_nd_a30 1
Dr_nd_a30 0 r_nd_a30 diode_nd2ps_06v0 area=5.62341e-08 pj=0.000948549
Bf_nd_a31 0 f_nd_a31 I=v(s)
Df_nd_a31 f_nd_a31 0 diode_nd2ps_06v0 area=7.49894e-08 pj=0.00109537
Vm_nd_a31 rn m_nd_a31 0
Rm_nd_a31 m_nd_a31 r_nd_a31 1
Dr_nd_a31 0 r_nd_a31 diode_nd2ps_06v0 area=7.49894e-08 pj=0.00109537
Bf_nd_a32 0 f_nd_a32 I=v(s)
Df_nd_a32 f_nd_a32 0 diode_nd2ps_06v0 area=1e-07 pj=0.00126491
Vm_nd_a32 rn m_nd_a32 0
Rm_nd_a32 m_nd_a32 r_nd_a32 1
Dr_nd_a32 0 r_nd_a32 diode_nd2ps_06v0 area=1e-07 pj=0.00126491
Bf_pd_a00 0 f_pd_a00 I=v(s)
Df_pd_a00 f_pd_a00 0 diode_pd2nw_06v0 area=1e-11 pj=1.26491e-05
Vm_pd_a00 rn m_pd_a00 0
Rm_pd_a00 m_pd_a00 r_pd_a00 1
Dr_pd_a00 0 r_pd_a00 diode_pd2nw_06v0 area=1e-11 pj=1.26491e-05
Bf_pd_a01 0 f_pd_a01 I=v(s)
Df_pd_a01 f_pd_a01 0 diode_pd2nw_06v0 area=1.33352e-11 pj=1.4607e-05
Vm_pd_a01 rn m_pd_a01 0
Rm_pd_a01 m_pd_a01 r_pd_a01 1
Dr_pd_a01 0 r_pd_a01 diode_pd2nw_06v0 area=1.33352e-11 pj=1.4607e-05
Bf_pd_a02 0 f_pd_a02 I=v(s)
Df_pd_a02 f_pd_a02 0 diode_pd2nw_06v0 area=1.77828e-11 pj=1.68679e-05
Vm_pd_a02 rn m_pd_a02 0
Rm_pd_a02 m_pd_a02 r_pd_a02 1
Dr_pd_a02 0 r_pd_a02 diode_pd2nw_06v0 area=1.77828e-11 pj=1.68679e-05
Bf_pd_a03 0 f_pd_a03 I=v(s)
Df_pd_a03 f_pd_a03 0 diode_pd2nw_06v0 area=2.37137e-11 pj=1.94787e-05
Vm_pd_a03 rn m_pd_a03 0
Rm_pd_a03 m_pd_a03 r_pd_a03 1
Dr_pd_a03 0 r_pd_a03 diode_pd2nw_06v0 area=2.37137e-11 pj=1.94787e-05
Bf_pd_a04 0 f_pd_a04 I=v(s)
Df_pd_a04 f_pd_a04 0 diode_pd2nw_06v0 area=3.16228e-11 pj=2.24937e-05
Vm_pd_a04 rn m_pd_a04 0
Rm_pd_a04 m_pd_a04 r_pd_a04 1
Dr_pd_a04 0 r_pd_a04 diode_pd2nw_06v0 area=3.16228e-11 pj=2.24937e-05
Bf_pd_a05 0 f_pd_a05 I=v(s)
Df_pd_a05 f_pd_a05 0 diode_pd2nw_06v0 area=4.21697e-11 pj=2.59753e-05
Vm_pd_a05 rn m_pd_a05 0
Rm_pd_a05 m_pd_a05 r_pd_a05 1
Dr_pd_a05 0 r_pd_a05 diode_pd2nw_06v0 area=4.21697e-11 pj=2.59753e-05
Bf_pd_a06 0 f_pd_a06 I=v(s)
Df_pd_a06 f_pd_a06 0 diode_pd2nw_06v0 area=5.62341e-11 pj=2.99958e-05
Vm_pd_a06 rn m_pd_a06 0
Rm_pd_a06 m_pd_a06 r_pd_a06 1
Dr_pd_a06 0 r_pd_a06 diode_pd2nw_06v0 area=5.62341e-11 pj=2.99958e-05
Bf_pd_a07 0 f_pd_a07 I=v(s)
Df_pd_a07 f_pd_a07 0 diode_pd2nw_06v0 area=7.49894e-11 pj=3.46386e-05
Vm_pd_a07 rn m_pd_a07 0
Rm_pd_a07 m_pd_a07 r_pd_a07 1
Dr_pd_a07 0 r_pd_a07 diode_pd2nw_06v0 area=7.49894e-11 pj=3.46386e-05
Bf_pd_a08 0 f_pd_a08 I=v(s)
Df_pd_a08 f_pd_a08 0 diode_pd2nw_06v0 area=1e-10 pj=4e-05
Vm_pd_a08 rn m_pd_a08 0
Rm_pd_a08 m_pd_a08 r_pd_a08 1
Dr_pd_a08 0 r_pd_a08 diode_pd2nw_06v0 area=1e-10 pj=4e-05
Bf_pd_a09 0 f_pd_a09 I=v(s)
Df_pd_a09 f_pd_a09 0 diode_pd2nw_06v0 area=1.33352e-10 pj=4.61913e-05
Vm_pd_a09 rn m_pd_a09 0
Rm_pd_a09 m_pd_a09 r_pd_a09 1
Dr_pd_a09 0 r_pd_a09 diode_pd2nw_06v0 area=1.33352e-10 pj=4.61913e-05
Bf_pd_a10 0 f_pd_a10 I=v(s)
Df_pd_a10 f_pd_a10 0 diode_pd2nw_06v0 area=1.77828e-10 pj=5.33409e-05
Vm_pd_a10 rn m_pd_a10 0
Rm_pd_a10 m_pd_a10 r_pd_a10 1
Dr_pd_a10 0 r_pd_a10 diode_pd2nw_06v0 area=1.77828e-10 pj=5.33409e-05
Bf_pd_a11 0 f_pd_a11 I=v(s)
Df_pd_a11 f_pd_a11 0 diode_pd2nw_06v0 area=2.37137e-10 pj=6.15971e-05
Vm_pd_a11 rn m_pd_a11 0
Rm_pd_a11 m_pd_a11 r_pd_a11 1
Dr_pd_a11 0 r_pd_a11 diode_pd2nw_06v0 area=2.37137e-10 pj=6.15971e-05
Bf_pd_a12 0 f_pd_a12 I=v(s)
Df_pd_a12 f_pd_a12 0 diode_pd2nw_06v0 area=3.16228e-10 pj=7.11312e-05
Vm_pd_a12 rn m_pd_a12 0
Rm_pd_a12 m_pd_a12 r_pd_a12 1
Dr_pd_a12 0 r_pd_a12 diode_pd2nw_06v0 area=3.16228e-10 pj=7.11312e-05
Bf_pd_a13 0 f_pd_a13 I=v(s)
Df_pd_a13 f_pd_a13 0 diode_pd2nw_06v0 area=4.21697e-10 pj=8.2141e-05
Vm_pd_a13 rn m_pd_a13 0
Rm_pd_a13 m_pd_a13 r_pd_a13 1
Dr_pd_a13 0 r_pd_a13 diode_pd2nw_06v0 area=4.21697e-10 pj=8.2141e-05
Bf_pd_a14 0 f_pd_a14 I=v(s)
Df_pd_a14 f_pd_a14 0 diode_pd2nw_06v0 area=5.62341e-10 pj=9.48549e-05
Vm_pd_a14 rn m_pd_a14 0
Rm_pd_a14 m_pd_a14 r_pd_a14 1
Dr_pd_a14 0 r_pd_a14 diode_pd2nw_06v0 area=5.62341e-10 pj=9.48549e-05
Bf_pd_a15 0 f_pd_a15 I=v(s)
Df_pd_a15 f_pd_a15 0 diode_pd2nw_06v0 area=7.49894e-10 pj=0.000109537
Vm_pd_a15 rn m_pd_a15 0
Rm_pd_a15 m_pd_a15 r_pd_a15 1
Dr_pd_a15 0 r_pd_a15 diode_pd2nw_06v0 area=7.49894e-10 pj=0.000109537
Bf_pd_a16 0 f_pd_a16 I=v(s)
Df_pd_a16 f_pd_a16 0 diode_pd2nw_06v0 area=1e-09 pj=0.000126491
Vm_pd_a16 rn m_pd_a16 0
Rm_pd_a16 m_pd_a16 r_pd_a16 1
Dr_pd_a16 0 r_pd_a16 diode_pd2nw_06v0 area=1e-09 pj=0.000126491
Bf_pd_a17 0 f_pd_a17 I=v(s)
Df_pd_a17 f_pd_a17 0 diode_pd2nw_06v0 area=1.33352e-09 pj=0.00014607
Vm_pd_a17 rn m_pd_a17 0
Rm_pd_a17 m_pd_a17 r_pd_a17 1
Dr_pd_a17 0 r_pd_a17 diode_pd2nw_06v0 area=1.33352e-09 pj=0.00014607
Bf_pd_a18 0 f_pd_a18 I=v(s)
Df_pd_a18 f_pd_a18 0 diode_pd2nw_06v0 area=1.77828e-09 pj=0.000168679
Vm_pd_a18 rn m_pd_a18 0
Rm_pd_a18 m_pd_a18 r_pd_a18 1
Dr_pd_a18 0 r_pd_a18 diode_pd2nw_06v0 area=1.77828e-09 pj=0.000168679
Bf_pd_a19 0 f_pd_a19 I=v(s)
Df_pd_a19 f_pd_a19 0 diode_pd2nw_06v0 area=2.37137e-09 pj=0.000194787
Vm_pd_a19 rn m_pd_a19 0
Rm_pd_a19 m_pd_a19 r_pd_a19 1
Dr_pd_a19 0 r_pd_a19 diode_pd2nw_06v0 area=2.37137e-09 pj=0.000194787
Bf_pd_a20 0 f_pd_a20 I=v(s)
Df_pd_a20 f_pd_a20 0 diode_pd2nw_06v0 area=3.16228e-09 pj=0.000224937
Vm_pd_a20 rn m_pd_a20 0
Rm_pd_a20 m_pd_a20 r_pd_a20 1
Dr_pd_a20 0 r_pd_a20 diode_pd2nw_06v0 area=3.16228e-09 pj=0.000224937
Bf_pd_a21 0 f_pd_a21 I=v(s)
Df_pd_a21 f_pd_a21 0 diode_pd2nw_06v0 area=4.21697e-09 pj=0.000259753
Vm_pd_a21 rn m_pd_a21 0
Rm_pd_a21 m_pd_a21 r_pd_a21 1
Dr_pd_a21 0 r_pd_a21 diode_pd2nw_06v0 area=4.21697e-09 pj=0.000259753
Bf_pd_a22 0 f_pd_a22 I=v(s)
Df_pd_a22 f_pd_a22 0 diode_pd2nw_06v0 area=5.62341e-09 pj=0.000299958
Vm_pd_a22 rn m_pd_a22 0
Rm_pd_a22 m_pd_a22 r_pd_a22 1
Dr_pd_a22 0 r_pd_a22 diode_pd2nw_06v0 area=5.62341e-09 pj=0.000299958
Bf_pd_a23 0 f_pd_a23 I=v(s)
Df_pd_a23 f_pd_a23 0 diode_pd2nw_06v0 area=7.49894e-09 pj=0.000346386
Vm_pd_a23 rn m_pd_a23 0
Rm_pd_a23 m_pd_a23 r_pd_a23 1
Dr_pd_a23 0 r_pd_a23 diode_pd2nw_06v0 area=7.49894e-09 pj=0.000346386
Bf_pd_a24 0 f_pd_a24 I=v(s)
Df_pd_a24 f_pd_a24 0 diode_pd2nw_06v0 area=1e-08 pj=0.0004
Vm_pd_a24 rn m_pd_a24 0
Rm_pd_a24 m_pd_a24 r_pd_a24 1
Dr_pd_a24 0 r_pd_a24 diode_pd2nw_06v0 area=1e-08 pj=0.0004
Bf_pd_a25 0 f_pd_a25 I=v(s)
Df_pd_a25 f_pd_a25 0 diode_pd2nw_06v0 area=1.33352e-08 pj=0.000461913
Vm_pd_a25 rn m_pd_a25 0
Rm_pd_a25 m_pd_a25 r_pd_a25 1
Dr_pd_a25 0 r_pd_a25 diode_pd2nw_06v0 area=1.33352e-08 pj=0.000461913
Bf_pd_a26 0 f_pd_a26 I=v(s)
Df_pd_a26 f_pd_a26 0 diode_pd2nw_06v0 area=1.77828e-08 pj=0.000533409
Vm_pd_a26 rn m_pd_a26 0
Rm_pd_a26 m_pd_a26 r_pd_a26 1
Dr_pd_a26 0 r_pd_a26 diode_pd2nw_06v0 area=1.77828e-08 pj=0.000533409
Bf_pd_a27 0 f_pd_a27 I=v(s)
Df_pd_a27 f_pd_a27 0 diode_pd2nw_06v0 area=2.37137e-08 pj=0.000615971
Vm_pd_a27 rn m_pd_a27 0
Rm_pd_a27 m_pd_a27 r_pd_a27 1
Dr_pd_a27 0 r_pd_a27 diode_pd2nw_06v0 area=2.37137e-08 pj=0.000615971
Bf_pd_a28 0 f_pd_a28 I=v(s)
Df_pd_a28 f_pd_a28 0 diode_pd2nw_06v0 area=3.16228e-08 pj=0.000711312
Vm_pd_a28 rn m_pd_a28 0
Rm_pd_a28 m_pd_a28 r_pd_a28 1
Dr_pd_a28 0 r_pd_a28 diode_pd2nw_06v0 area=3.16228e-08 pj=0.000711312
Bf_pd_a29 0 f_pd_a29 I=v(s)
Df_pd_a29 f_pd_a29 0 diode_pd2nw_06v0 area=4.21697e-08 pj=0.00082141
Vm_pd_a29 rn m_pd_a29 0
Rm_pd_a29 m_pd_a29 r_pd_a29 1
Dr_pd_a29 0 r_pd_a29 diode_pd2nw_06v0 area=4.21697e-08 pj=0.00082141
Bf_pd_a30 0 f_pd_a30 I=v(s)
Df_pd_a30 f_pd_a30 0 diode_pd2nw_06v0 area=5.62341e-08 pj=0.000948549
Vm_pd_a30 rn m_pd_a30 0
Rm_pd_a30 m_pd_a30 r_pd_a30 1
Dr_pd_a30 0 r_pd_a30 diode_pd2nw_06v0 area=5.62341e-08 pj=0.000948549
Bf_pd_a31 0 f_pd_a31 I=v(s)
Df_pd_a31 f_pd_a31 0 diode_pd2nw_06v0 area=7.49894e-08 pj=0.00109537
Vm_pd_a31 rn m_pd_a31 0
Rm_pd_a31 m_pd_a31 r_pd_a31 1
Dr_pd_a31 0 r_pd_a31 diode_pd2nw_06v0 area=7.49894e-08 pj=0.00109537
Bf_pd_a32 0 f_pd_a32 I=v(s)
Df_pd_a32 f_pd_a32 0 diode_pd2nw_06v0 area=1e-07 pj=0.00126491
Vm_pd_a32 rn m_pd_a32 0
Rm_pd_a32 m_pd_a32 r_pd_a32 1
Dr_pd_a32 0 r_pd_a32 diode_pd2nw_06v0 area=1e-07 pj=0.00126491
