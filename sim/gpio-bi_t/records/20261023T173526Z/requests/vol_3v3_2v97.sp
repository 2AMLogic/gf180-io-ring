* gf180mcu_fd_io__bi_t, deck vol, 3v3 mode: VOL: A=0, OE=1; sink current from DVDD into PAD
* Generated by gen_requests.py; foundry convention VDD = DVDD.
.include /home/ubuntu/.volare/volare/gf180mcu/versions/c6d73a35f524070e85faff4a6a9eef49553ebc2b/gf180mcuD/libs.tech/ngspice/design.ngspice
.include bi_t.sp
.param dvdd=2.97 iload=0.002
Vdvdd dvdd 0 {dvdd}
Vvdd vdd 0 {dvdd}
Vvss vss 0 0
Vdvss dvss 0 0
Va a 0 0
Voe oe 0 {dvdd}
Vie ie 0 0
Vpu pu 0 0
Vpd pd 0 0
Vcs cs 0 0
Vsl sl 0 0
Vpdrv0 pdrv0 0 0
Vpdrv1 pdrv1 0 0
Iload dvdd pad DC {iload}
Xdut a cs dvdd dvss ie oe pad pd pdrv0 pdrv1 pu sl vdd vss y gf180mcu_fd_io__bi_t
