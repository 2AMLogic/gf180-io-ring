* gf180mcu_fd_io__bi_t, deck edges, 5v mode: 10-90 % rise/fall into 15 pF; PDRV=00, SL=0
* Generated by gen_requests.py; foundry convention VDD = DVDD.
.include /home/ubuntu/.volare/volare/gf180mcu/versions/c6d73a35f524070e85faff4a6a9eef49553ebc2b/gf180mcuD/libs.tech/ngspice/design.ngspice
.include bi_t.sp
.param dvdd=4.5 iload=0.004
Vdvdd dvdd 0 {dvdd}
Vvdd vdd 0 {dvdd}
Vvss vss 0 0
Vdvss dvss 0 0
Va a 0 PULSE(0 {dvdd} 2n 0.1n 0.1n 40n 80n)
Voe oe 0 {dvdd}
Vie ie 0 0
Vpu pu 0 0
Vpd pd 0 0
Vcs cs 0 0
Vsl sl 0 0
Vpdrv0 pdrv0 0 0
Vpdrv1 pdrv1 0 0
Cl pad 0 15p
Xdut a cs dvdd dvss ie oe pad pd pdrv0 pdrv1 pu sl vdd vss y gf180mcu_fd_io__bi_t
