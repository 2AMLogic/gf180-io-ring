* gf180mcu_fd_io__bi_t, deck cap, 5v mode: PAD small-signal capacitance at 1 MHz, input mode, PAD biased at DVDD/2
* Generated by gen_requests.py; foundry convention VDD = DVDD.
.include /home/ubuntu/.volare/volare/gf180mcu/versions/c6d73a35f524070e85faff4a6a9eef49553ebc2b/gf180mcuD/libs.tech/ngspice/design.ngspice
.include bi_t.sp
.param dvdd=5.0 iload=0.004
Vdvdd dvdd 0 {dvdd}
Vvdd vdd 0 {dvdd}
Vvss vss 0 0
Vdvss dvss 0 0
Va a 0 0
Voe oe 0 0
Vie ie 0 {dvdd}
Vpu pu 0 0
Vpd pd 0 0
Vcs cs 0 0
Vsl sl 0 0
Vpdrv0 pdrv0 0 0
Vpdrv1 pdrv1 0 0
Vpad pad 0 DC {0.5*dvdd} AC 1
Xdut a cs dvdd dvss ie oe pad pd pdrv0 pdrv1 pu sl vdd vss y gf180mcu_fd_io__bi_t
