* own-design gpio, deck vol, 5v mode: VOL: A=0, OE=1; sink current from DVDD into PAD
* Generated by sim/mc/gen_requests.py. Core VDD = 3.3 V.
.include /home/ubuntu/.volare/volare/gf180mcu/versions/c6d73a35f524070e85faff4a6a9eef49553ebc2b/gf180mcuD/libs.tech/ngspice/design.ngspice
.include gpio.spice
.control
set num_threads=1
.endc
.param sw_stat_global=1 sw_stat_mismatch=1
.param dvdd=5.0 vdd=3.3 iload=0.004
Vdvdd dvdd 0 {dvdd}
Vvdd vdd 0 {vdd}
Vvss vss 0 0
Vdvss dvss 0 0
Va a 0 0
Voe oe 0 {vdd}
Vie ie 0 0
Vpu pu 0 0
Vpd pd 0 0
Iload dvdd pad DC {iload}
Xdut a oe ie pu pd y pad dvdd vdd dvss vss gpio
