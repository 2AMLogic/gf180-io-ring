* own-design gpio, deck xfer, 3v3 mode: input transfer curve, slow PAD ramp up then down (receiver thresholds)
* Generated by sim/mc/gen_requests.py. Core VDD = 3.3 V.
.include /home/ubuntu/.volare/volare/gf180mcu/versions/c6d73a35f524070e85faff4a6a9eef49553ebc2b/gf180mcuD/libs.tech/ngspice/design.ngspice
.include gpio.spice
.control
set num_threads=1
.endc
.param sw_stat_global=1 sw_stat_mismatch=1
.param dvdd=3.3 vdd=3.3 iload=0.002
Vdvdd dvdd 0 {dvdd}
Vvdd vdd 0 {vdd}
Vvss vss 0 0
Vdvss dvss 0 0
Va a 0 0
Voe oe 0 0
Vie ie 0 {vdd}
Vpu pu 0 0
Vpd pd 0 0
Vpad pad 0 PWL(0 0 100u {dvdd} 200u 0)
Xdut a oe ie pu pd y pad dvdd vdd dvss vss gpio
