** sch_path: /home/ubuntu/GitHub/gf180-io-ring/.loom/worktrees/issue-14/design/corner.sch
.subckt corner DVDD VDD DVSS VSS
*.iopin DVDD
*.iopin DVSS
*.iopin VDD
*.iopin VSS
.ends
